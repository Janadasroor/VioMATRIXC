* Digital Inverter Test for XSpice with Bridges
V1 1 0 pulse(0 5 1n 1n 1n 10n 20n)

* ADC Bridge: Analog to Digital
A_adc [1] [d_in] adc1
.model adc1 adc_bridge(in_low=0.1 in_high=0.9)

* DAC Bridge: Digital to Analog
A_dac [d_out] [2] dac1
.model dac1 dac_bridge(out_low=0 out_high=5)

* XSpice d_inverter model
A_inv d_in d_out inv1
.model inv1 d_inverter(rise_delay=0.5n fall_delay=0.3n)

.control
tran 0.1n 50n
plot v(1) v(2)
quit
.endc
.end
