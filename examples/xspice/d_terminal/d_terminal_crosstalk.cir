* d_terminal full-duplex cross-connect
* Two terminals talk to each other simultaneously.
* Each terminal's TX connects to the other's RX.
*
* Interact via PTY:
*   screen /tmp/tty_a   (type characters -> term1 -> tx_b -> term2 RX)
*   screen /tmp/tty_b   (type characters -> term2 -> tx_a -> term1 RX)
.model term1 d_terminal(baud=115200 pty="/tmp/tty_a")
.model term2 d_terminal(baud=115200 pty="/tmp/tty_b")
.model bridge dac_bridge(out_low=0 out_high=5)

* Port order: d_in d_out
A1 rx_a tx_b term1    * term1 TX -> wire tx_b -> term2 RX
A2 rx_b tx_a term2    * term2 TX -> wire tx_a -> term1 RX

* Probe both TX lines
A_dac1 [tx_a] [tx_a_an 0] bridge
A_dac2 [tx_b] [tx_b_an 0] bridge
R_load1 tx_a_an 0 10k
R_load2 tx_b_an 0 10k

.tran 1u 5m uic

.control
set filetype=ascii
run
write /tmp/dterm_raw.txt v(tx_a_an) v(tx_b_an)
.endc
